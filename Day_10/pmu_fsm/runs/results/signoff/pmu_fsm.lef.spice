* NGSPICE file created from pmu_fsm.ext - technology: sky130A

* Black-box entry subcircuit for sky130_fd_sc_hd__fill_2 abstract view
.subckt sky130_fd_sc_hd__fill_2 VGND VNB VPB VPWR
.ends

* Black-box entry subcircuit for sky130_ef_sc_hd__decap_12 abstract view
.subckt sky130_ef_sc_hd__decap_12 VPWR VGND VPB VNB
.ends

* Black-box entry subcircuit for sky130_fd_sc_hd__a211oi_1 abstract view
.subckt sky130_fd_sc_hd__a211oi_1 A1 A2 B1 C1 VGND VNB VPB VPWR Y
.ends

* Black-box entry subcircuit for sky130_fd_sc_hd__inv_2 abstract view
.subckt sky130_fd_sc_hd__inv_2 A VGND VNB VPB VPWR Y
.ends

* Black-box entry subcircuit for sky130_fd_sc_hd__decap_3 abstract view
.subckt sky130_fd_sc_hd__decap_3 VGND VNB VPB VPWR
.ends

* Black-box entry subcircuit for sky130_fd_sc_hd__tapvpwrvgnd_1 abstract view
.subckt sky130_fd_sc_hd__tapvpwrvgnd_1 VGND VPWR
.ends

* Black-box entry subcircuit for sky130_fd_sc_hd__clkbuf_1 abstract view
.subckt sky130_fd_sc_hd__clkbuf_1 A VGND VNB VPB VPWR X
.ends

* Black-box entry subcircuit for sky130_fd_sc_hd__dfrtp_1 abstract view
.subckt sky130_fd_sc_hd__dfrtp_1 CLK D RESET_B VGND VNB VPB VPWR Q
.ends

* Black-box entry subcircuit for sky130_fd_sc_hd__decap_8 abstract view
.subckt sky130_fd_sc_hd__decap_8 VGND VNB VPB VPWR
.ends

* Black-box entry subcircuit for sky130_fd_sc_hd__decap_4 abstract view
.subckt sky130_fd_sc_hd__decap_4 VGND VNB VPB VPWR
.ends

* Black-box entry subcircuit for sky130_fd_sc_hd__clkbuf_2 abstract view
.subckt sky130_fd_sc_hd__clkbuf_2 A VGND VNB VPB VPWR X
.ends

* Black-box entry subcircuit for sky130_fd_sc_hd__buf_4 abstract view
.subckt sky130_fd_sc_hd__buf_4 A VGND VNB VPB VPWR X
.ends

* Black-box entry subcircuit for sky130_fd_sc_hd__decap_6 abstract view
.subckt sky130_fd_sc_hd__decap_6 VGND VNB VPB VPWR
.ends

* Black-box entry subcircuit for sky130_fd_sc_hd__nor2_1 abstract view
.subckt sky130_fd_sc_hd__nor2_1 A B VGND VNB VPB VPWR Y
.ends

* Black-box entry subcircuit for sky130_fd_sc_hd__dfrtp_4 abstract view
.subckt sky130_fd_sc_hd__dfrtp_4 CLK D RESET_B VGND VNB VPB VPWR Q
.ends

* Black-box entry subcircuit for sky130_fd_sc_hd__fill_1 abstract view
.subckt sky130_fd_sc_hd__fill_1 VGND VNB VPB VPWR
.ends

* Black-box entry subcircuit for sky130_fd_sc_hd__o21a_1 abstract view
.subckt sky130_fd_sc_hd__o21a_1 A1 A2 B1 VGND VNB VPB VPWR X
.ends

* Black-box entry subcircuit for sky130_fd_sc_hd__nand2_1 abstract view
.subckt sky130_fd_sc_hd__nand2_1 A B VGND VNB VPB VPWR Y
.ends

* Black-box entry subcircuit for sky130_fd_sc_hd__bufinv_16 abstract view
.subckt sky130_fd_sc_hd__bufinv_16 A VGND VNB VPB VPWR Y
.ends

* Black-box entry subcircuit for sky130_fd_sc_hd__dfstp_1 abstract view
.subckt sky130_fd_sc_hd__dfstp_1 CLK D SET_B VGND VNB VPB VPWR Q
.ends

* Black-box entry subcircuit for sky130_fd_sc_hd__a21oi_1 abstract view
.subckt sky130_fd_sc_hd__a21oi_1 A1 A2 B1 VGND VNB VPB VPWR Y
.ends

* Black-box entry subcircuit for sky130_fd_sc_hd__buf_2 abstract view
.subckt sky130_fd_sc_hd__buf_2 A VGND VNB VPB VPWR X
.ends

* Black-box entry subcircuit for sky130_fd_sc_hd__o211ai_2 abstract view
.subckt sky130_fd_sc_hd__o211ai_2 A1 A2 B1 C1 VGND VNB VPB VPWR Y
.ends

* Black-box entry subcircuit for sky130_fd_sc_hd__xor2_1 abstract view
.subckt sky130_fd_sc_hd__xor2_1 A B VGND VNB VPB VPWR X
.ends

* Black-box entry subcircuit for sky130_fd_sc_hd__nand3_1 abstract view
.subckt sky130_fd_sc_hd__nand3_1 A B C VGND VNB VPB VPWR Y
.ends

* Black-box entry subcircuit for sky130_fd_sc_hd__clkbuf_16 abstract view
.subckt sky130_fd_sc_hd__clkbuf_16 A VGND VNB VPB VPWR X
.ends

* Black-box entry subcircuit for sky130_fd_sc_hd__or2_1 abstract view
.subckt sky130_fd_sc_hd__or2_1 A B VGND VNB VPB VPWR X
.ends

* Black-box entry subcircuit for sky130_fd_sc_hd__or2b_1 abstract view
.subckt sky130_fd_sc_hd__or2b_1 A B_N VGND VNB VPB VPWR X
.ends

* Black-box entry subcircuit for sky130_fd_sc_hd__inv_6 abstract view
.subckt sky130_fd_sc_hd__inv_6 A VGND VNB VPB VPWR Y
.ends

* Black-box entry subcircuit for sky130_fd_sc_hd__buf_1 abstract view
.subckt sky130_fd_sc_hd__buf_1 A VGND VNB VPB VPWR X
.ends

* Black-box entry subcircuit for sky130_fd_sc_hd__o211a_1 abstract view
.subckt sky130_fd_sc_hd__o211a_1 A1 A2 B1 C1 VGND VNB VPB VPWR X
.ends

* Black-box entry subcircuit for sky130_fd_sc_hd__o21ai_1 abstract view
.subckt sky130_fd_sc_hd__o21ai_1 A1 A2 B1 VGND VNB VPB VPWR Y
.ends

* Black-box entry subcircuit for sky130_fd_sc_hd__a21o_1 abstract view
.subckt sky130_fd_sc_hd__a21o_1 A1 A2 B1 VGND VNB VPB VPWR X
.ends

* Black-box entry subcircuit for sky130_fd_sc_hd__conb_1 abstract view
.subckt sky130_fd_sc_hd__conb_1 VGND VNB VPB VPWR HI LO
.ends

* Black-box entry subcircuit for sky130_fd_sc_hd__or3b_1 abstract view
.subckt sky130_fd_sc_hd__or3b_1 A B C_N VGND VNB VPB VPWR X
.ends

* Black-box entry subcircuit for sky130_fd_sc_hd__o21bai_1 abstract view
.subckt sky130_fd_sc_hd__o21bai_1 A1 A2 B1_N VGND VNB VPB VPWR Y
.ends

* Black-box entry subcircuit for sky130_fd_sc_hd__or3_1 abstract view
.subckt sky130_fd_sc_hd__or3_1 A B C VGND VNB VPB VPWR X
.ends

* Black-box entry subcircuit for sky130_fd_sc_hd__nand3_4 abstract view
.subckt sky130_fd_sc_hd__nand3_4 A B C VGND VNB VPB VPWR Y
.ends

* Black-box entry subcircuit for sky130_fd_sc_hd__o311a_1 abstract view
.subckt sky130_fd_sc_hd__o311a_1 A1 A2 A3 B1 C1 VGND VNB VPB VPWR X
.ends

* Black-box entry subcircuit for sky130_fd_sc_hd__nand2b_1 abstract view
.subckt sky130_fd_sc_hd__nand2b_1 A_N B VGND VNB VPB VPWR Y
.ends

* Black-box entry subcircuit for sky130_fd_sc_hd__and2_1 abstract view
.subckt sky130_fd_sc_hd__and2_1 A B VGND VNB VPB VPWR X
.ends

.subckt pmu_fsm VGND VPWR clk clk_gate_en clk_stable dvfs_ctrl[0] dvfs_ctrl[1] error
+ pwr_gate_en pwr_stable pwr_state[0] pwr_state[1] req_idle req_off req_sleep reset_ctrl
+ reset_n retention_en retention_ready retention_restore retention_save seq_busy wake_up
XFILLER_0_7_81 VGND VGND VPWR VPWR sky130_fd_sc_hd__fill_2
XFILLER_0_18_29 VPWR VGND VPWR VGND sky130_ef_sc_hd__decap_12
X_200_ _066_ _095_ _026_ _100_ VGND VGND VPWR VPWR net10 sky130_fd_sc_hd__a211oi_1
X_131_ seq_timer\[0\] VGND VGND VPWR VPWR _071_ sky130_fd_sc_hd__inv_2
XFILLER_0_10_41 VPWR VGND VPWR VGND sky130_ef_sc_hd__decap_12
XFILLER_0_19_125 VGND VGND VPWR VPWR sky130_fd_sc_hd__decap_3
XTAP_TAPCELL_ROW_5_56 VGND VPWR sky130_fd_sc_hd__tapvpwrvgnd_1
XFILLER_0_21_62 VPWR VGND VPWR VGND sky130_ef_sc_hd__decap_12
XTAP_TAPCELL_ROW_20_87 VGND VPWR sky130_fd_sc_hd__tapvpwrvgnd_1
XFILLER_0_16_51 VGND VGND VPWR VPWR sky130_fd_sc_hd__fill_2
XTAP_TAPCELL_ROW_15_76 VGND VPWR sky130_fd_sc_hd__tapvpwrvgnd_1
Xwire19 net10 VGND VGND VPWR VPWR net19 sky130_fd_sc_hd__clkbuf_1
XPHY_EDGE_ROW_21_Right_21 VGND VGND VPWR VPWR sky130_fd_sc_hd__decap_3
XPHY_EDGE_ROW_12_Right_12 VGND VGND VPWR VPWR sky130_fd_sc_hd__decap_3
X_130_ seq_timer\[1\] VGND VGND VPWR VPWR _070_ sky130_fd_sc_hd__inv_2
X_259_ clknet_1_0__leaf_clk net7 reset_n VGND VGND VPWR VPWR sync_stage1\[0\] sky130_fd_sc_hd__dfrtp_1
XFILLER_0_19_104 VGND VGND VPWR VPWR sky130_fd_sc_hd__decap_8
XFILLER_0_19_73 VGND VGND VPWR VPWR sky130_fd_sc_hd__decap_4
XFILLER_0_10_53 VGND VGND VPWR VPWR sky130_fd_sc_hd__decap_4
XTAP_TAPCELL_ROW_5_57 VGND VPWR sky130_fd_sc_hd__tapvpwrvgnd_1
XFILLER_0_21_85 VPWR VGND VPWR VGND sky130_ef_sc_hd__decap_12
XFILLER_0_21_74 VGND VGND VPWR VPWR sky130_fd_sc_hd__decap_8
XFILLER_0_21_41 VPWR VGND VPWR VGND sky130_ef_sc_hd__decap_12
XFILLER_0_16_85 VPWR VGND VPWR VGND sky130_ef_sc_hd__decap_12
XPHY_EDGE_ROW_16_Left_38 VGND VGND VPWR VPWR sky130_fd_sc_hd__decap_3
XFILLER_0_6_29 VGND VGND VPWR VPWR sky130_fd_sc_hd__decap_4
XPHY_EDGE_ROW_6_Right_6 VGND VGND VPWR VPWR sky130_fd_sc_hd__decap_3
XTAP_TAPCELL_ROW_15_77 VGND VPWR sky130_fd_sc_hd__tapvpwrvgnd_1
Xoutput10 net19 VGND VGND VPWR VPWR error sky130_fd_sc_hd__clkbuf_2
Xoutput8 net8 VGND VGND VPWR VPWR clk_gate_en sky130_fd_sc_hd__buf_4
XFILLER_0_7_72 VGND VGND VPWR VPWR sky130_fd_sc_hd__decap_6
XPHY_EDGE_ROW_19_Left_41 VGND VGND VPWR VPWR sky130_fd_sc_hd__decap_3
XPHY_EDGE_ROW_4_Left_26 VGND VGND VPWR VPWR sky130_fd_sc_hd__decap_3
X_189_ curr_state\[0\] _016_ VGND VGND VPWR VPWR _022_ sky130_fd_sc_hd__nor2_1
X_258_ clknet_1_0__leaf_clk next_state\[2\] reset_n VGND VGND VPWR VPWR curr_state\[2\]
+ sky130_fd_sc_hd__dfrtp_4
XFILLER_0_21_97 VPWR VGND VPWR VGND sky130_ef_sc_hd__decap_12
XFILLER_0_21_53 VGND VGND VPWR VPWR sky130_fd_sc_hd__decap_3
XFILLER_0_1_96 VPWR VGND VPWR VGND sky130_ef_sc_hd__decap_12
XFILLER_0_6_19 VGND VGND VPWR VPWR sky130_fd_sc_hd__decap_8
XFILLER_0_16_97 VPWR VGND VPWR VGND sky130_ef_sc_hd__decap_12
XFILLER_0_12_100 VPWR VGND VPWR VGND sky130_ef_sc_hd__decap_12
Xoutput11 net11 VGND VGND VPWR VPWR pwr_gate_en sky130_fd_sc_hd__buf_4
Xoutput9 net9 VGND VGND VPWR VPWR dvfs_ctrl[1] sky130_fd_sc_hd__clkbuf_2
XFILLER_0_7_40 VGND VGND VPWR VPWR sky130_fd_sc_hd__fill_1
XFILLER_0_7_51 VGND VGND VPWR VPWR sky130_fd_sc_hd__fill_1
XFILLER_0_13_43 VGND VGND VPWR VPWR sky130_fd_sc_hd__decap_4
XFILLER_0_13_87 VGND VGND VPWR VPWR sky130_fd_sc_hd__fill_1
XPHY_EDGE_ROW_20_Left_42 VGND VGND VPWR VPWR sky130_fd_sc_hd__decap_3
XFILLER_0_4_85 VPWR VGND VPWR VGND sky130_ef_sc_hd__decap_12
X_188_ curr_state\[0\] _066_ _064_ VGND VGND VPWR VPWR _000_ sky130_fd_sc_hd__o21a_1
X_257_ clknet_1_0__leaf_clk next_state\[1\] reset_n VGND VGND VPWR VPWR curr_state\[1\]
+ sky130_fd_sc_hd__dfrtp_1
XFILLER_0_10_33 VGND VGND VPWR VPWR sky130_fd_sc_hd__fill_1
XFILLER_0_10_88 VPWR VGND VPWR VGND sky130_ef_sc_hd__decap_12
XFILLER_0_16_109 VPWR VGND VPWR VGND sky130_ef_sc_hd__decap_12
XFILLER_0_1_75 VGND VGND VPWR VPWR sky130_fd_sc_hd__fill_1
XFILLER_0_12_112 VPWR VGND VPWR VGND sky130_ef_sc_hd__decap_12
Xoutput12 net12 VGND VGND VPWR VPWR pwr_state[0] sky130_fd_sc_hd__clkbuf_2
XFILLER_0_5_109 VGND VGND VPWR VPWR sky130_fd_sc_hd__decap_3
XFILLER_0_7_63 VGND VGND VPWR VPWR sky130_fd_sc_hd__decap_3
XFILLER_0_4_97 VPWR VGND VPWR VGND sky130_ef_sc_hd__decap_12
X_256_ clknet_1_0__leaf_clk next_state\[0\] reset_n VGND VGND VPWR VPWR curr_state\[0\]
+ sky130_fd_sc_hd__dfrtp_4
X_187_ _014_ _021_ VGND VGND VPWR VPWR next_state\[2\] sky130_fd_sc_hd__nand2_1
Xclkload0 clknet_1_1__leaf_clk VGND VGND VPWR VPWR clkload0/Y sky130_fd_sc_hd__bufinv_16
XFILLER_0_21_11 VPWR VGND VPWR VGND sky130_ef_sc_hd__decap_12
X_239_ clknet_1_1__leaf_clk _001_ reset_n VGND VGND VPWR VPWR net9 sky130_fd_sc_hd__dfstp_1
XFILLER_0_15_110 VGND VGND VPWR VPWR sky130_fd_sc_hd__fill_2
XFILLER_0_21_113 VPWR VGND VPWR VGND sky130_ef_sc_hd__decap_12
XFILLER_0_12_124 VGND VGND VPWR VPWR sky130_fd_sc_hd__decap_4
Xoutput13 net13 VGND VGND VPWR VPWR pwr_state[1] sky130_fd_sc_hd__clkbuf_2
XTAP_TAPCELL_ROW_21_90 VGND VPWR sky130_fd_sc_hd__tapvpwrvgnd_1
XPHY_EDGE_ROW_19_Right_19 VGND VGND VPWR VPWR sky130_fd_sc_hd__decap_3
XFILLER_0_4_121 VGND VGND VPWR VPWR sky130_fd_sc_hd__decap_6
XFILLER_0_7_31 VGND VGND VPWR VPWR sky130_fd_sc_hd__fill_2
XFILLER_0_1_113 VPWR VGND VPWR VGND sky130_ef_sc_hd__decap_12
XFILLER_0_4_21 VGND VGND VPWR VPWR sky130_fd_sc_hd__decap_6
X_255_ clknet_1_1__leaf_clk _113_ reset_n VGND VGND VPWR VPWR net13 sky130_fd_sc_hd__dfrtp_1
X_186_ _104_ _015_ _020_ VGND VGND VPWR VPWR _021_ sky130_fd_sc_hd__a21oi_1
XFILLER_0_10_57 VGND VGND VPWR VPWR sky130_fd_sc_hd__fill_1
XFILLER_0_19_77 VGND VGND VPWR VPWR sky130_fd_sc_hd__fill_1
XFILLER_0_21_23 VGND VGND VPWR VPWR sky130_fd_sc_hd__decap_4
X_238_ _056_ _035_ VGND VGND VPWR VPWR _011_ sky130_fd_sc_hd__nor2_1
X_169_ curr_state\[1\] VGND VGND VPWR VPWR _106_ sky130_fd_sc_hd__inv_2
XFILLER_0_8_108 VPWR VGND VPWR VGND sky130_ef_sc_hd__decap_12
XFILLER_0_16_23 VGND VGND VPWR VPWR sky130_fd_sc_hd__fill_1
XFILLER_0_18_3 VPWR VGND VPWR VGND sky130_ef_sc_hd__decap_12
XTAP_TAPCELL_ROW_21_91 VGND VPWR sky130_fd_sc_hd__tapvpwrvgnd_1
Xoutput14 net14 VGND VGND VPWR VPWR reset_ctrl sky130_fd_sc_hd__buf_2
XFILLER_0_13_24 VGND VGND VPWR VPWR sky130_fd_sc_hd__decap_4
XFILLER_0_4_44 VPWR VGND VPWR VGND sky130_ef_sc_hd__decap_12
X_254_ clknet_1_1__leaf_clk _112_ reset_n VGND VGND VPWR VPWR net12 sky130_fd_sc_hd__dfrtp_1
X_185_ _088_ _016_ _018_ _019_ VGND VGND VPWR VPWR _020_ sky130_fd_sc_hd__o211ai_2
XFILLER_0_10_25 VGND VGND VPWR VPWR sky130_fd_sc_hd__decap_3
XFILLER_0_21_57 VGND VGND VPWR VPWR sky130_fd_sc_hd__fill_2
X_237_ seq_timer\[7\] _054_ VGND VGND VPWR VPWR _056_ sky130_fd_sc_hd__xor2_1
X_168_ _101_ _063_ VGND VGND VPWR VPWR _105_ sky130_fd_sc_hd__nor2_1
XPHY_EDGE_ROW_11_Left_33 VGND VGND VPWR VPWR sky130_fd_sc_hd__decap_3
XPHY_EDGE_ROW_1_Right_1 VGND VGND VPWR VPWR sky130_fd_sc_hd__decap_3
Xoutput15 net15 VGND VGND VPWR VPWR retention_en sky130_fd_sc_hd__buf_4
XFILLER_0_7_55 VGND VGND VPWR VPWR sky130_fd_sc_hd__fill_1
XFILLER_0_4_78 VGND VGND VPWR VPWR sky130_fd_sc_hd__decap_6
XFILLER_0_19_35 VPWR VGND VPWR VGND sky130_ef_sc_hd__decap_12
XFILLER_0_19_13 VGND VGND VPWR VPWR sky130_fd_sc_hd__fill_2
X_184_ _002_ _081_ req_off_sync VGND VGND VPWR VPWR _019_ sky130_fd_sc_hd__nand3_1
X_253_ clknet_1_1__leaf_clk _115_ reset_n VGND VGND VPWR VPWR net14 sky130_fd_sc_hd__dfrtp_1
XFILLER_0_10_37 VGND VGND VPWR VPWR sky130_fd_sc_hd__fill_1
X_236_ _055_ _035_ VGND VGND VPWR VPWR _010_ sky130_fd_sc_hd__nor2_1
X_167_ seq_timer\[2\] _072_ _074_ VGND VGND VPWR VPWR _104_ sky130_fd_sc_hd__a21oi_1
XFILLER_0_1_57 VPWR VGND VPWR VGND sky130_ef_sc_hd__decap_12
XFILLER_0_15_102 VGND VGND VPWR VPWR sky130_fd_sc_hd__decap_8
XFILLER_0_15_113 VPWR VGND VPWR VGND sky130_ef_sc_hd__decap_12
XFILLER_0_16_58 VGND VGND VPWR VPWR sky130_fd_sc_hd__fill_1
X_219_ _042_ _035_ VGND VGND VPWR VPWR _006_ sky130_fd_sc_hd__nor2_1
Xoutput16 net16 VGND VGND VPWR VPWR retention_restore sky130_fd_sc_hd__buf_2
Xclkbuf_0_clk clk VGND VGND VPWR VPWR clknet_0_clk sky130_fd_sc_hd__clkbuf_16
XPHY_EDGE_ROW_15_Right_15 VGND VGND VPWR VPWR sky130_fd_sc_hd__decap_3
XTAP_TAPCELL_ROW_3_52 VGND VPWR sky130_fd_sc_hd__tapvpwrvgnd_1
XTAP_TAPCELL_ROW_13_72 VGND VPWR sky130_fd_sc_hd__tapvpwrvgnd_1
XFILLER_0_14_80 VGND VGND VPWR VPWR sky130_fd_sc_hd__decap_4
XFILLER_0_19_47 VGND VGND VPWR VPWR sky130_fd_sc_hd__fill_1
X_183_ curr_state\[2\] _106_ VGND VGND VPWR VPWR _002_ sky130_fd_sc_hd__nor2_1
X_252_ clknet_1_0__leaf_clk _114_ reset_n VGND VGND VPWR VPWR net16 sky130_fd_sc_hd__dfrtp_1
X_235_ _053_ _054_ VGND VGND VPWR VPWR _055_ sky130_fd_sc_hd__nand2_1
XFILLER_0_1_69 VGND VGND VPWR VPWR sky130_fd_sc_hd__decap_6
X_166_ _097_ _102_ VGND VGND VPWR VPWR _103_ sky130_fd_sc_hd__nand2_1
XFILLER_0_15_125 VGND VGND VPWR VPWR sky130_fd_sc_hd__decap_3
X_218_ _040_ _041_ VGND VGND VPWR VPWR _042_ sky130_fd_sc_hd__nand2_1
XFILLER_0_16_37 VGND VGND VPWR VPWR sky130_fd_sc_hd__decap_3
X_149_ _080_ _086_ VGND VGND VPWR VPWR _087_ sky130_fd_sc_hd__nand2_1
Xoutput17 net17 VGND VGND VPWR VPWR retention_save sky130_fd_sc_hd__buf_2
XFILLER_0_7_111 VGND VGND VPWR VPWR sky130_fd_sc_hd__fill_1
XFILLER_0_7_57 VGND VGND VPWR VPWR sky130_fd_sc_hd__decap_3
XTAP_TAPCELL_ROW_3_53 VGND VPWR sky130_fd_sc_hd__tapvpwrvgnd_1
XTAP_TAPCELL_ROW_13_73 VGND VPWR sky130_fd_sc_hd__tapvpwrvgnd_1
X_182_ _017_ _084_ _088_ VGND VGND VPWR VPWR _018_ sky130_fd_sc_hd__nand3_1
X_251_ clknet_1_0__leaf_clk _003_ reset_n VGND VGND VPWR VPWR net17 sky130_fd_sc_hd__dfrtp_1
XFILLER_0_21_27 VGND VGND VPWR VPWR sky130_fd_sc_hd__fill_1
X_234_ _050_ seq_timer\[6\] VGND VGND VPWR VPWR _054_ sky130_fd_sc_hd__nand2_1
XFILLER_0_1_15 VGND VGND VPWR VPWR sky130_fd_sc_hd__fill_1
X_165_ _100_ _101_ _068_ VGND VGND VPWR VPWR _102_ sky130_fd_sc_hd__nand3_1
X_217_ _036_ _039_ VGND VGND VPWR VPWR _041_ sky130_fd_sc_hd__nand2_1
XFILLER_0_16_27 VGND VGND VPWR VPWR sky130_fd_sc_hd__fill_1
X_148_ _083_ _084_ _085_ VGND VGND VPWR VPWR _086_ sky130_fd_sc_hd__nand3_1
Xoutput18 net20 VGND VGND VPWR VPWR seq_busy sky130_fd_sc_hd__clkbuf_2
XPHY_EDGE_ROW_15_Left_37 VGND VGND VPWR VPWR sky130_fd_sc_hd__decap_3
XFILLER_0_17_70 VPWR VGND VPWR VGND sky130_ef_sc_hd__decap_12
XPHY_EDGE_ROW_5_Right_5 VGND VGND VPWR VPWR sky130_fd_sc_hd__decap_3
XFILLER_0_7_7 VPWR VGND VPWR VGND sky130_ef_sc_hd__decap_12
XFILLER_0_13_28 VGND VGND VPWR VPWR sky130_fd_sc_hd__fill_1
XPHY_EDGE_ROW_18_Left_40 VGND VGND VPWR VPWR sky130_fd_sc_hd__decap_3
X_181_ _079_ _085_ VGND VGND VPWR VPWR _017_ sky130_fd_sc_hd__nand2_1
X_250_ clknet_1_0__leaf_clk _116_ reset_n VGND VGND VPWR VPWR net15 sky130_fd_sc_hd__dfrtp_1
XTAP_TAPCELL_ROW_0_44 VGND VPWR sky130_fd_sc_hd__tapvpwrvgnd_1
XFILLER_0_10_18 VGND VGND VPWR VPWR sky130_fd_sc_hd__fill_1
XFILLER_0_10_29 VGND VGND VPWR VPWR sky130_fd_sc_hd__decap_4
XTAP_TAPCELL_ROW_9_64 VGND VPWR sky130_fd_sc_hd__tapvpwrvgnd_1
XPHY_EDGE_ROW_3_Left_25 VGND VGND VPWR VPWR sky130_fd_sc_hd__decap_3
X_233_ seq_timer\[6\] _050_ VGND VGND VPWR VPWR _053_ sky130_fd_sc_hd__or2_1
X_164_ net6 VGND VGND VPWR VPWR _101_ sky130_fd_sc_hd__inv_2
XTAP_TAPCELL_ROW_19_84 VGND VPWR sky130_fd_sc_hd__tapvpwrvgnd_1
X_216_ _039_ _036_ VGND VGND VPWR VPWR _040_ sky130_fd_sc_hd__or2_1
X_147_ req_sleep_sync VGND VGND VPWR VPWR _085_ sky130_fd_sc_hd__inv_2
XFILLER_0_7_113 VPWR VGND VPWR VGND sky130_ef_sc_hd__decap_12
XFILLER_0_4_127 VGND VGND VPWR VPWR sky130_fd_sc_hd__fill_1
XFILLER_0_17_82 VGND VGND VPWR VPWR sky130_fd_sc_hd__decap_4
XPHY_EDGE_ROW_20_Right_20 VGND VGND VPWR VPWR sky130_fd_sc_hd__decap_3
XFILLER_0_1_108 VGND VGND VPWR VPWR sky130_fd_sc_hd__decap_4
XPHY_EDGE_ROW_11_Right_11 VGND VGND VPWR VPWR sky130_fd_sc_hd__decap_3
XFILLER_0_4_27 VGND VGND VPWR VPWR sky130_fd_sc_hd__fill_1
X_180_ _064_ _066_ VGND VGND VPWR VPWR _016_ sky130_fd_sc_hd__nand2_1
XTAP_TAPCELL_ROW_0_45 VGND VPWR sky130_fd_sc_hd__tapvpwrvgnd_1
XTAP_TAPCELL_ROW_9_65 VGND VPWR sky130_fd_sc_hd__tapvpwrvgnd_1
X_232_ _052_ _035_ VGND VGND VPWR VPWR _009_ sky130_fd_sc_hd__nor2_1
XFILLER_0_21_29 VPWR VGND VPWR VGND sky130_ef_sc_hd__decap_12
X_163_ _062_ _099_ VGND VGND VPWR VPWR _100_ sky130_fd_sc_hd__nor2_1
XFILLER_0_21_109 VGND VGND VPWR VPWR sky130_fd_sc_hd__decap_3
XTAP_TAPCELL_ROW_19_85 VGND VPWR sky130_fd_sc_hd__tapvpwrvgnd_1
XFILLER_0_16_29 VGND VGND VPWR VPWR sky130_fd_sc_hd__decap_8
XFILLER_0_20_120 VGND VGND VPWR VPWR sky130_fd_sc_hd__decap_8
X_146_ curr_state\[2\] _066_ VGND VGND VPWR VPWR _084_ sky130_fd_sc_hd__nor2_1
XFILLER_0_7_103 VGND VGND VPWR VPWR sky130_fd_sc_hd__decap_8
X_215_ seq_timer\[2\] VGND VGND VPWR VPWR _039_ sky130_fd_sc_hd__inv_2
XFILLER_0_7_125 VGND VGND VPWR VPWR sky130_fd_sc_hd__decap_3
XFILLER_0_11_120 VGND VGND VPWR VPWR sky130_fd_sc_hd__decap_4
XFILLER_0_17_94 VPWR VGND VPWR VGND sky130_ef_sc_hd__decap_12
X_129_ _063_ _068_ VGND VGND VPWR VPWR _069_ sky130_fd_sc_hd__nand2_1
XFILLER_0_14_3 VGND VGND VPWR VPWR sky130_fd_sc_hd__decap_4
XTAP_TAPCELL_ROW_0_46 VGND VPWR sky130_fd_sc_hd__tapvpwrvgnd_1
X_231_ _050_ _051_ VGND VGND VPWR VPWR _052_ sky130_fd_sc_hd__or2b_1
X_162_ _058_ _098_ VGND VGND VPWR VPWR _099_ sky130_fd_sc_hd__nor2_1
XFILLER_0_11_85 VPWR VGND VPWR VGND sky130_ef_sc_hd__decap_12
XTAP_TAPCELL_ROW_10_66 VGND VPWR sky130_fd_sc_hd__tapvpwrvgnd_1
Xinput1 clk_stable VGND VGND VPWR VPWR net1 sky130_fd_sc_hd__clkbuf_1
X_214_ _038_ _035_ VGND VGND VPWR VPWR _005_ sky130_fd_sc_hd__nor2_1
X_145_ _081_ _082_ VGND VGND VPWR VPWR _083_ sky130_fd_sc_hd__nand2_1
XFILLER_0_16_19 VGND VGND VPWR VPWR sky130_fd_sc_hd__decap_4
XFILLER_0_2_83 VGND VGND VPWR VPWR sky130_fd_sc_hd__fill_1
XFILLER_0_16_7 VPWR VGND VPWR VGND sky130_ef_sc_hd__decap_12
X_128_ _067_ VGND VGND VPWR VPWR _068_ sky130_fd_sc_hd__inv_2
XFILLER_0_0_121 VGND VGND VPWR VPWR sky130_fd_sc_hd__fill_2
XPHY_EDGE_ROW_9_Right_9 VGND VGND VPWR VPWR sky130_fd_sc_hd__decap_3
XFILLER_0_8_71 VGND VGND VPWR VPWR sky130_fd_sc_hd__fill_2
XFILLER_0_8_82 VGND VGND VPWR VPWR sky130_fd_sc_hd__fill_2
XFILLER_0_4_29 VGND VGND VPWR VPWR sky130_fd_sc_hd__fill_2
XFILLER_0_14_85 VPWR VGND VPWR VGND sky130_ef_sc_hd__decap_12
XTAP_TAPCELL_ROW_0_47 VGND VPWR sky130_fd_sc_hd__tapvpwrvgnd_1
XFILLER_0_18_127 VGND VGND VPWR VPWR sky130_fd_sc_hd__fill_1
X_230_ _047_ _049_ VGND VGND VPWR VPWR _051_ sky130_fd_sc_hd__nand2_1
X_161_ seq_timer\[3\] seq_timer\[2\] VGND VGND VPWR VPWR _098_ sky130_fd_sc_hd__nand2_1
XFILLER_0_11_97 VPWR VGND VPWR VGND sky130_ef_sc_hd__decap_12
Xinput2 pwr_stable VGND VGND VPWR VPWR net2 sky130_fd_sc_hd__clkbuf_1
XPHY_EDGE_ROW_7_Left_29 VGND VGND VPWR VPWR sky130_fd_sc_hd__decap_3
XTAP_TAPCELL_ROW_10_67 VGND VPWR sky130_fd_sc_hd__tapvpwrvgnd_1
X_213_ _036_ _037_ VGND VGND VPWR VPWR _038_ sky130_fd_sc_hd__nand2_1
X_144_ req_idle_sync VGND VGND VPWR VPWR _082_ sky130_fd_sc_hd__inv_2
XTAP_TAPCELL_ROW_21_88 VGND VPWR sky130_fd_sc_hd__tapvpwrvgnd_1
XFILLER_0_2_51 VGND VGND VPWR VPWR sky130_fd_sc_hd__decap_4
XFILLER_0_17_41 VPWR VGND VPWR VGND sky130_ef_sc_hd__decap_12
X_127_ _065_ _066_ VGND VGND VPWR VPWR _067_ sky130_fd_sc_hd__nand2_1
XFILLER_0_0_111 VGND VGND VPWR VPWR sky130_fd_sc_hd__fill_1
XFILLER_0_14_97 VPWR VGND VPWR VGND sky130_ef_sc_hd__decap_12
X_160_ _096_ _068_ VGND VGND VPWR VPWR _097_ sky130_fd_sc_hd__nand2_1
XPHY_EDGE_ROW_18_Right_18 VGND VGND VPWR VPWR sky130_fd_sc_hd__decap_3
Xinput3 req_idle VGND VGND VPWR VPWR net3 sky130_fd_sc_hd__clkbuf_1
X_212_ _028_ _070_ VGND VGND VPWR VPWR _037_ sky130_fd_sc_hd__nand2_1
X_143_ curr_state\[0\] VGND VGND VPWR VPWR _081_ sky130_fd_sc_hd__inv_2
XTAP_TAPCELL_ROW_6_58 VGND VPWR sky130_fd_sc_hd__tapvpwrvgnd_1
XTAP_TAPCELL_ROW_21_89 VGND VPWR sky130_fd_sc_hd__tapvpwrvgnd_1
XFILLER_0_2_85 VGND VGND VPWR VPWR sky130_fd_sc_hd__fill_1
XFILLER_0_2_41 VGND VGND VPWR VPWR sky130_fd_sc_hd__decap_6
XFILLER_0_17_64 VGND VGND VPWR VPWR sky130_fd_sc_hd__decap_3
XFILLER_0_17_53 VGND VGND VPWR VPWR sky130_fd_sc_hd__decap_3
XFILLER_0_4_109 VPWR VGND VPWR VGND sky130_ef_sc_hd__decap_12
XFILLER_0_7_19 VPWR VGND VPWR VGND sky130_ef_sc_hd__decap_12
X_126_ curr_state\[1\] VGND VGND VPWR VPWR _066_ sky130_fd_sc_hd__clkbuf_2
XFILLER_0_17_86 VGND VGND VPWR VPWR sky130_fd_sc_hd__fill_1
XTAP_TAPCELL_ROW_16_78 VGND VPWR sky130_fd_sc_hd__tapvpwrvgnd_1
XPHY_EDGE_ROW_10_Left_32 VGND VGND VPWR VPWR sky130_fd_sc_hd__decap_3
XPHY_EDGE_ROW_0_Right_0 VGND VGND VPWR VPWR sky130_fd_sc_hd__decap_3
XFILLER_0_18_107 VPWR VGND VPWR VGND sky130_ef_sc_hd__decap_12
Xinput4 req_off VGND VGND VPWR VPWR net4 sky130_fd_sc_hd__clkbuf_1
XFILLER_0_11_11 VGND VGND VPWR VPWR sky130_fd_sc_hd__decap_3
XFILLER_0_11_33 VGND VGND VPWR VPWR sky130_fd_sc_hd__fill_1
XFILLER_0_11_55 VGND VGND VPWR VPWR sky130_fd_sc_hd__fill_1
X_142_ curr_state\[2\] _079_ _077_ VGND VGND VPWR VPWR _080_ sky130_fd_sc_hd__o21a_1
XTAP_TAPCELL_ROW_6_59 VGND VPWR sky130_fd_sc_hd__tapvpwrvgnd_1
XFILLER_0_14_121 VGND VGND VPWR VPWR sky130_fd_sc_hd__decap_6
X_211_ _070_ _028_ VGND VGND VPWR VPWR _036_ sky130_fd_sc_hd__or2_1
XFILLER_0_11_113 VGND VGND VPWR VPWR sky130_fd_sc_hd__decap_4
XFILLER_0_11_124 VGND VGND VPWR VPWR sky130_fd_sc_hd__fill_1
X_125_ curr_state\[0\] _064_ VGND VGND VPWR VPWR _065_ sky130_fd_sc_hd__nor2_1
XTAP_TAPCELL_ROW_16_79 VGND VPWR sky130_fd_sc_hd__tapvpwrvgnd_1
XFILLER_0_0_113 VGND VGND VPWR VPWR sky130_fd_sc_hd__decap_8
XFILLER_0_14_7 VGND VGND VPWR VPWR sky130_fd_sc_hd__fill_1
XFILLER_0_18_119 VGND VGND VPWR VPWR sky130_fd_sc_hd__decap_8
XFILLER_0_5_53 VGND VGND VPWR VPWR sky130_fd_sc_hd__decap_3
Xinput5 req_sleep VGND VGND VPWR VPWR net5 sky130_fd_sc_hd__clkbuf_1
XFILLER_0_11_23 VGND VGND VPWR VPWR sky130_fd_sc_hd__fill_1
X_141_ req_off_sync VGND VGND VPWR VPWR _079_ sky130_fd_sc_hd__inv_2
X_210_ _029_ _035_ VGND VGND VPWR VPWR _004_ sky130_fd_sc_hd__nor2_1
X_124_ curr_state\[2\] VGND VGND VPWR VPWR _064_ sky130_fd_sc_hd__inv_6
XFILLER_0_8_64 VGND VGND VPWR VPWR sky130_fd_sc_hd__fill_1
XFILLER_0_11_57 VPWR VGND VPWR VGND sky130_ef_sc_hd__decap_12
Xinput6 retention_ready VGND VGND VPWR VPWR net6 sky130_fd_sc_hd__buf_1
X_140_ _064_ _078_ VGND VGND VPWR VPWR net18 sky130_fd_sc_hd__nor2_1
XPHY_EDGE_ROW_14_Right_14 VGND VGND VPWR VPWR sky130_fd_sc_hd__decap_3
XFILLER_0_2_55 VGND VGND VPWR VPWR sky130_fd_sc_hd__fill_1
XFILLER_0_17_23 VGND VGND VPWR VPWR sky130_fd_sc_hd__fill_2
XTAP_TAPCELL_ROW_7_60 VGND VPWR sky130_fd_sc_hd__tapvpwrvgnd_1
X_123_ _059_ _062_ VGND VGND VPWR VPWR _063_ sky130_fd_sc_hd__nor2_1
XFILLER_0_0_126 VGND VGND VPWR VPWR sky130_fd_sc_hd__fill_2
XPHY_EDGE_ROW_4_Right_4 VGND VGND VPWR VPWR sky130_fd_sc_hd__decap_3
XPHY_EDGE_ROW_14_Left_36 VGND VGND VPWR VPWR sky130_fd_sc_hd__decap_3
XTAP_TAPCELL_ROW_17_80 VGND VPWR sky130_fd_sc_hd__tapvpwrvgnd_1
XFILLER_0_12_6 VPWR VGND VPWR VGND sky130_ef_sc_hd__decap_12
XFILLER_0_5_77 VPWR VGND VPWR VGND sky130_ef_sc_hd__decap_12
Xinput7 wake_up VGND VGND VPWR VPWR net7 sky130_fd_sc_hd__clkbuf_1
XPHY_EDGE_ROW_2_Left_24 VGND VGND VPWR VPWR sky130_fd_sc_hd__decap_3
XFILLER_0_2_23 VGND VGND VPWR VPWR sky130_fd_sc_hd__decap_4
X_199_ _065_ _101_ VGND VGND VPWR VPWR _026_ sky130_fd_sc_hd__nand2_1
XFILLER_0_6_121 VGND VGND VPWR VPWR sky130_fd_sc_hd__decap_6
XFILLER_0_17_57 VGND VGND VPWR VPWR sky130_fd_sc_hd__decap_4
X_122_ _060_ _061_ VGND VGND VPWR VPWR _062_ sky130_fd_sc_hd__nand2_1
XTAP_TAPCELL_ROW_7_61 VGND VPWR sky130_fd_sc_hd__tapvpwrvgnd_1
XFILLER_0_3_113 VPWR VGND VPWR VGND sky130_ef_sc_hd__decap_12
XFILLER_0_0_105 VGND VGND VPWR VPWR sky130_fd_sc_hd__decap_6
XFILLER_0_8_55 VGND VGND VPWR VPWR sky130_fd_sc_hd__decap_4
XTAP_TAPCELL_ROW_17_81 VGND VPWR sky130_fd_sc_hd__tapvpwrvgnd_1
XFILLER_0_5_23 VGND VGND VPWR VPWR sky130_fd_sc_hd__fill_1
XFILLER_0_5_89 VPWR VGND VPWR VGND sky130_ef_sc_hd__decap_12
XFILLER_0_15_90 VPWR VGND VPWR VGND sky130_ef_sc_hd__decap_12
XFILLER_0_11_37 VPWR VGND VPWR VGND sky130_ef_sc_hd__decap_12
X_198_ _070_ seq_timer\[0\] _090_ _063_ VGND VGND VPWR VPWR _003_ sky130_fd_sc_hd__o211a_1
XFILLER_0_2_79 VGND VGND VPWR VPWR sky130_fd_sc_hd__decap_4
X_121_ seq_timer\[6\] seq_timer\[7\] VGND VGND VPWR VPWR _061_ sky130_fd_sc_hd__nor2_1
XFILLER_0_17_36 VGND VGND VPWR VPWR sky130_fd_sc_hd__fill_2
XFILLER_0_3_125 VGND VGND VPWR VPWR sky130_fd_sc_hd__decap_3
Xclkbuf_1_0__f_clk clknet_0_clk VGND VGND VPWR VPWR clknet_1_0__leaf_clk sky130_fd_sc_hd__clkbuf_16
XFILLER_0_5_57 VGND VGND VPWR VPWR sky130_fd_sc_hd__fill_2
XFILLER_0_11_27 VGND VGND VPWR VPWR sky130_fd_sc_hd__decap_6
XFILLER_0_11_49 VGND VGND VPWR VPWR sky130_fd_sc_hd__decap_6
X_266_ clknet_1_0__leaf_clk sync_stage1\[3\] reset_n VGND VGND VPWR VPWR req_idle_sync
+ sky130_fd_sc_hd__dfrtp_1
X_197_ _069_ _076_ _024_ VGND VGND VPWR VPWR _116_ sky130_fd_sc_hd__o21ai_1
XFILLER_0_2_47 VGND VGND VPWR VPWR sky130_fd_sc_hd__fill_1
XPHY_EDGE_ROW_10_Right_10 VGND VGND VPWR VPWR sky130_fd_sc_hd__decap_3
X_120_ seq_timer\[5\] seq_timer\[4\] VGND VGND VPWR VPWR _060_ sky130_fd_sc_hd__nor2_1
X_249_ clknet_1_0__leaf_clk _002_ reset_n VGND VGND VPWR VPWR net11 sky130_fd_sc_hd__dfrtp_1
XFILLER_0_8_35 VGND VGND VPWR VPWR sky130_fd_sc_hd__fill_1
XPHY_EDGE_ROW_8_Right_8 VGND VGND VPWR VPWR sky130_fd_sc_hd__decap_3
XFILLER_0_17_113 VPWR VGND VPWR VGND sky130_ef_sc_hd__decap_12
XFILLER_0_11_17 VGND VGND VPWR VPWR sky130_fd_sc_hd__decap_6
XFILLER_0_14_127 VGND VGND VPWR VPWR sky130_fd_sc_hd__fill_1
XFILLER_0_20_108 VPWR VGND VPWR VGND sky130_ef_sc_hd__decap_12
X_265_ clknet_1_0__leaf_clk sync_stage1\[2\] reset_n VGND VGND VPWR VPWR req_sleep_sync
+ sky130_fd_sc_hd__dfrtp_1
X_196_ _076_ _068_ _023_ VGND VGND VPWR VPWR _115_ sky130_fd_sc_hd__a21o_1
XPHY_EDGE_ROW_6_Left_28 VGND VGND VPWR VPWR sky130_fd_sc_hd__decap_3
X_248_ clknet_1_0__leaf_clk _000_ reset_n VGND VGND VPWR VPWR net8 sky130_fd_sc_hd__dfrtp_1
X_179_ _091_ VGND VGND VPWR VPWR _015_ sky130_fd_sc_hd__inv_2
XPHY_EDGE_ROW_9_Left_31 VGND VGND VPWR VPWR sky130_fd_sc_hd__decap_3
Xpmu_fsm_21 VGND VGND VPWR VPWR dvfs_ctrl[0] pmu_fsm_21/LO sky130_fd_sc_hd__conb_1
XTAP_TAPCELL_ROW_4_54 VGND VPWR sky130_fd_sc_hd__tapvpwrvgnd_1
XFILLER_0_17_125 VGND VGND VPWR VPWR sky130_fd_sc_hd__decap_3
XFILLER_0_10_7 VGND VGND VPWR VPWR sky130_fd_sc_hd__decap_8
XTAP_TAPCELL_ROW_14_74 VGND VPWR sky130_fd_sc_hd__tapvpwrvgnd_1
XFILLER_0_6_80 VGND VGND VPWR VPWR sky130_fd_sc_hd__decap_4
X_195_ _025_ VGND VGND VPWR VPWR _113_ sky130_fd_sc_hd__clkbuf_1
X_264_ clknet_1_0__leaf_clk sync_stage1\[1\] reset_n VGND VGND VPWR VPWR req_off_sync
+ sky130_fd_sc_hd__dfrtp_1
XFILLER_0_2_27 VGND VGND VPWR VPWR sky130_fd_sc_hd__fill_1
XFILLER_0_11_109 VGND VGND VPWR VPWR sky130_fd_sc_hd__decap_3
XFILLER_0_12_61 VGND VGND VPWR VPWR sky130_fd_sc_hd__decap_6
XFILLER_0_12_83 VGND VGND VPWR VPWR sky130_fd_sc_hd__fill_1
X_247_ clknet_1_1__leaf_clk _011_ reset_n VGND VGND VPWR VPWR seq_timer\[7\] sky130_fd_sc_hd__dfrtp_1
XFILLER_0_17_28 VGND VGND VPWR VPWR sky130_fd_sc_hd__decap_8
X_178_ _013_ _103_ VGND VGND VPWR VPWR _014_ sky130_fd_sc_hd__nor2_1
XFILLER_0_8_48 VGND VGND VPWR VPWR sky130_fd_sc_hd__fill_1
XFILLER_0_8_59 VGND VGND VPWR VPWR sky130_fd_sc_hd__fill_1
XTAP_TAPCELL_ROW_4_55 VGND VPWR sky130_fd_sc_hd__tapvpwrvgnd_1
XFILLER_0_14_29 VGND VGND VPWR VPWR sky130_fd_sc_hd__fill_1
XFILLER_0_20_83 VGND VGND VPWR VPWR sky130_fd_sc_hd__fill_1
XTAP_TAPCELL_ROW_14_75 VGND VPWR sky130_fd_sc_hd__tapvpwrvgnd_1
X_263_ clknet_1_0__leaf_clk sync_stage1\[0\] reset_n VGND VGND VPWR VPWR wake_up_sync
+ sky130_fd_sc_hd__dfrtp_1
X_194_ _015_ _023_ _024_ VGND VGND VPWR VPWR _025_ sky130_fd_sc_hd__or3b_1
X_246_ clknet_1_1__leaf_clk _010_ reset_n VGND VGND VPWR VPWR seq_timer\[6\] sky130_fd_sc_hd__dfrtp_1
X_177_ _012_ _105_ VGND VGND VPWR VPWR _013_ sky130_fd_sc_hd__nor2_1
X_229_ _049_ _047_ VGND VGND VPWR VPWR _050_ sky130_fd_sc_hd__nor2_1
XFILLER_0_8_27 VGND VGND VPWR VPWR sky130_fd_sc_hd__fill_1
XPHY_EDGE_ROW_17_Right_17 VGND VGND VPWR VPWR sky130_fd_sc_hd__decap_3
XFILLER_0_15_51 VGND VGND VPWR VPWR sky130_fd_sc_hd__decap_4
XFILLER_0_9_113 VPWR VGND VPWR VGND sky130_ef_sc_hd__decap_12
X_262_ clknet_1_0__leaf_clk net3 reset_n VGND VGND VPWR VPWR sync_stage1\[3\] sky130_fd_sc_hd__dfrtp_1
X_193_ _022_ _107_ VGND VGND VPWR VPWR _024_ sky130_fd_sc_hd__nor2_1
XFILLER_0_2_29 VPWR VGND VPWR VGND sky130_ef_sc_hd__decap_12
XFILLER_0_6_127 VGND VGND VPWR VPWR sky130_fd_sc_hd__fill_1
XFILLER_0_10_100 VPWR VGND VPWR VGND sky130_ef_sc_hd__decap_12
X_245_ clknet_1_1__leaf_clk _009_ reset_n VGND VGND VPWR VPWR seq_timer\[5\] sky130_fd_sc_hd__dfrtp_1
X_176_ _100_ _107_ VGND VGND VPWR VPWR _012_ sky130_fd_sc_hd__nand2_1
X_228_ seq_timer\[5\] VGND VGND VPWR VPWR _049_ sky130_fd_sc_hd__inv_2
XFILLER_0_8_39 VGND VGND VPWR VPWR sky130_fd_sc_hd__decap_6
X_159_ _059_ _062_ _095_ VGND VGND VPWR VPWR _096_ sky130_fd_sc_hd__o21bai_1
XFILLER_0_20_96 VPWR VGND VPWR VGND sky130_ef_sc_hd__decap_12
XFILLER_0_20_85 VGND VGND VPWR VPWR sky130_fd_sc_hd__decap_3
XFILLER_0_17_106 VGND VGND VPWR VPWR sky130_fd_sc_hd__decap_6
XFILLER_0_9_125 VGND VGND VPWR VPWR sky130_fd_sc_hd__decap_3
XFILLER_0_14_109 VPWR VGND VPWR VGND sky130_ef_sc_hd__decap_12
X_261_ clknet_1_0__leaf_clk net5 reset_n VGND VGND VPWR VPWR sync_stage1\[2\] sky130_fd_sc_hd__dfrtp_1
X_192_ curr_state\[2\] _077_ VGND VGND VPWR VPWR _023_ sky130_fd_sc_hd__nor2_1
XFILLER_0_10_112 VPWR VGND VPWR VGND sky130_ef_sc_hd__decap_12
X_244_ clknet_1_1__leaf_clk _008_ reset_n VGND VGND VPWR VPWR seq_timer\[4\] sky130_fd_sc_hd__dfrtp_1
XFILLER_0_3_109 VGND VGND VPWR VPWR sky130_fd_sc_hd__decap_3
X_175_ _111_ VGND VGND VPWR VPWR next_state\[1\] sky130_fd_sc_hd__clkbuf_1
XFILLER_0_3_51 VGND VGND VPWR VPWR sky130_fd_sc_hd__fill_1
X_227_ _048_ _035_ VGND VGND VPWR VPWR _008_ sky130_fd_sc_hd__nor2_1
XFILLER_0_19_7 VGND VGND VPWR VPWR sky130_fd_sc_hd__decap_3
XFILLER_0_18_85 VGND VGND VPWR VPWR sky130_fd_sc_hd__fill_2
XFILLER_0_18_41 VPWR VGND VPWR VGND sky130_ef_sc_hd__decap_12
XFILLER_0_8_29 VGND VGND VPWR VPWR sky130_fd_sc_hd__decap_6
X_158_ net2 net1 VGND VGND VPWR VPWR _095_ sky130_fd_sc_hd__nand2_1
XFILLER_0_20_75 VGND VGND VPWR VPWR sky130_fd_sc_hd__decap_8
XPHY_EDGE_ROW_3_Right_3 VGND VGND VPWR VPWR sky130_fd_sc_hd__decap_3
XFILLER_0_0_52 VGND VGND VPWR VPWR sky130_fd_sc_hd__decap_4
XPHY_EDGE_ROW_13_Left_35 VGND VGND VPWR VPWR sky130_fd_sc_hd__decap_3
Xclkbuf_1_1__f_clk clknet_0_clk VGND VGND VPWR VPWR clknet_1_1__leaf_clk sky130_fd_sc_hd__clkbuf_16
XTAP_TAPCELL_ROW_1_48 VGND VPWR sky130_fd_sc_hd__tapvpwrvgnd_1
X_260_ clknet_1_0__leaf_clk net4 reset_n VGND VGND VPWR VPWR sync_stage1\[1\] sky130_fd_sc_hd__dfrtp_1
X_191_ curr_state\[2\] _066_ _081_ VGND VGND VPWR VPWR _112_ sky130_fd_sc_hd__a21oi_1
XFILLER_0_10_124 VGND VGND VPWR VPWR sky130_fd_sc_hd__decap_4
XTAP_TAPCELL_ROW_11_68 VGND VPWR sky130_fd_sc_hd__tapvpwrvgnd_1
XPHY_EDGE_ROW_1_Left_23 VGND VGND VPWR VPWR sky130_fd_sc_hd__decap_3
X_174_ _103_ _109_ _110_ VGND VGND VPWR VPWR _111_ sky130_fd_sc_hd__or3_1
X_243_ clknet_1_1__leaf_clk _007_ reset_n VGND VGND VPWR VPWR seq_timer\[3\] sky130_fd_sc_hd__dfrtp_1
XFILLER_0_3_74 VPWR VGND VPWR VGND sky130_ef_sc_hd__decap_12
Xwire20 net18 VGND VGND VPWR VPWR net20 sky130_fd_sc_hd__buf_1
X_226_ _046_ _047_ VGND VGND VPWR VPWR _048_ sky130_fd_sc_hd__nand2_1
XFILLER_0_18_53 VGND VGND VPWR VPWR sky130_fd_sc_hd__decap_6
X_157_ _094_ VGND VGND VPWR VPWR next_state\[0\] sky130_fd_sc_hd__inv_2
X_209_ _030_ _031_ _034_ VGND VGND VPWR VPWR _035_ sky130_fd_sc_hd__nand3_4
XFILLER_0_9_84 VPWR VGND VPWR VGND sky130_ef_sc_hd__decap_12
XPHY_EDGE_ROW_13_Right_13 VGND VGND VPWR VPWR sky130_fd_sc_hd__decap_3
XFILLER_0_15_32 VGND VGND VPWR VPWR sky130_fd_sc_hd__decap_3
XTAP_TAPCELL_ROW_1_49 VGND VPWR sky130_fd_sc_hd__tapvpwrvgnd_1
XFILLER_0_6_85 VPWR VGND VPWR VGND sky130_ef_sc_hd__decap_12
XFILLER_0_13_111 VGND VGND VPWR VPWR sky130_fd_sc_hd__fill_1
X_190_ _022_ VGND VGND VPWR VPWR _001_ sky130_fd_sc_hd__inv_2
XTAP_TAPCELL_ROW_11_69 VGND VPWR sky130_fd_sc_hd__tapvpwrvgnd_1
XFILLER_0_12_88 VPWR VGND VPWR VGND sky130_ef_sc_hd__decap_12
X_173_ curr_state\[0\] wake_up_sync _079_ _064_ _066_ VGND VGND VPWR VPWR _110_ sky130_fd_sc_hd__o311a_1
X_242_ clknet_1_1__leaf_clk _006_ reset_n VGND VGND VPWR VPWR seq_timer\[2\] sky130_fd_sc_hd__dfrtp_1
XFILLER_0_3_86 VGND VGND VPWR VPWR sky130_fd_sc_hd__decap_3
X_225_ net20 seq_timer\[4\] _099_ VGND VGND VPWR VPWR _047_ sky130_fd_sc_hd__nand3_1
X_156_ _092_ _093_ VGND VGND VPWR VPWR _094_ sky130_fd_sc_hd__nand2_1
X_139_ _077_ VGND VGND VPWR VPWR _078_ sky130_fd_sc_hd__inv_2
X_208_ _032_ _033_ VGND VGND VPWR VPWR _034_ sky130_fd_sc_hd__nand2_1
XFILLER_0_9_41 VGND VGND VPWR VPWR sky130_fd_sc_hd__fill_1
XFILLER_0_9_96 VPWR VGND VPWR VGND sky130_ef_sc_hd__decap_12
XFILLER_0_15_44 VGND VGND VPWR VPWR sky130_fd_sc_hd__decap_4
XFILLER_0_15_55 VGND VGND VPWR VPWR sky130_fd_sc_hd__fill_1
XFILLER_0_6_97 VPWR VGND VPWR VGND sky130_ef_sc_hd__decap_12
XFILLER_0_6_109 VPWR VGND VPWR VGND sky130_ef_sc_hd__decap_12
XFILLER_0_12_67 VGND VGND VPWR VPWR sky130_fd_sc_hd__fill_1
X_241_ clknet_1_1__leaf_clk _005_ reset_n VGND VGND VPWR VPWR seq_timer\[1\] sky130_fd_sc_hd__dfrtp_1
X_172_ _091_ _104_ _108_ VGND VGND VPWR VPWR _109_ sky130_fd_sc_hd__o21ai_1
XFILLER_0_3_65 VGND VGND VPWR VPWR sky130_fd_sc_hd__fill_1
X_224_ seq_timer\[4\] _044_ VGND VGND VPWR VPWR _046_ sky130_fd_sc_hd__nand2b_1
X_155_ _078_ curr_state\[2\] VGND VGND VPWR VPWR _093_ sky130_fd_sc_hd__nand2_1
XFILLER_0_18_66 VPWR VGND VPWR VGND sky130_ef_sc_hd__decap_12
XFILLER_0_18_22 VGND VGND VPWR VPWR sky130_fd_sc_hd__decap_6
XFILLER_0_20_23 VGND VGND VPWR VPWR sky130_fd_sc_hd__fill_2
X_207_ _092_ curr_state\[0\] _093_ VGND VGND VPWR VPWR _033_ sky130_fd_sc_hd__nand3_1
X_138_ curr_state\[0\] curr_state\[1\] VGND VGND VPWR VPWR _077_ sky130_fd_sc_hd__nand2_1
XPHY_EDGE_ROW_17_Left_39 VGND VGND VPWR VPWR sky130_fd_sc_hd__decap_3
XFILLER_0_16_121 VGND VGND VPWR VPWR sky130_fd_sc_hd__decap_6
XPHY_EDGE_ROW_7_Right_7 VGND VGND VPWR VPWR sky130_fd_sc_hd__decap_3
XFILLER_0_6_7 VPWR VGND VPWR VGND sky130_ef_sc_hd__decap_12
XFILLER_0_13_113 VPWR VGND VPWR VGND sky130_ef_sc_hd__decap_12
XTAP_TAPCELL_ROW_2_50 VGND VPWR sky130_fd_sc_hd__tapvpwrvgnd_1
X_171_ _105_ _107_ VGND VGND VPWR VPWR _108_ sky130_fd_sc_hd__nand2_1
X_240_ clknet_1_1__leaf_clk _004_ reset_n VGND VGND VPWR VPWR seq_timer\[0\] sky130_fd_sc_hd__dfrtp_1
XFILLER_0_3_55 VGND VGND VPWR VPWR sky130_fd_sc_hd__fill_1
X_223_ _045_ _035_ VGND VGND VPWR VPWR _007_ sky130_fd_sc_hd__nor2_1
XPHY_EDGE_ROW_5_Left_27 VGND VGND VPWR VPWR sky130_fd_sc_hd__decap_3
XTAP_TAPCELL_ROW_12_70 VGND VPWR sky130_fd_sc_hd__tapvpwrvgnd_1
X_154_ _089_ _091_ VGND VGND VPWR VPWR _092_ sky130_fd_sc_hd__nand2_1
X_206_ _094_ _081_ VGND VGND VPWR VPWR _032_ sky130_fd_sc_hd__nand2_1
X_137_ _069_ _076_ VGND VGND VPWR VPWR _114_ sky130_fd_sc_hd__nor2_1
XPHY_EDGE_ROW_8_Left_30 VGND VGND VPWR VPWR sky130_fd_sc_hd__decap_3
XFILLER_0_15_57 VGND VGND VPWR VPWR sky130_fd_sc_hd__fill_2
XFILLER_0_15_68 VGND VGND VPWR VPWR sky130_fd_sc_hd__fill_2
XFILLER_0_9_108 VGND VGND VPWR VPWR sky130_fd_sc_hd__decap_4
XFILLER_0_6_33 VGND VGND VPWR VPWR sky130_fd_sc_hd__fill_1
XFILLER_0_6_55 VGND VGND VPWR VPWR sky130_fd_sc_hd__fill_1
XFILLER_0_13_103 VGND VGND VPWR VPWR sky130_fd_sc_hd__decap_8
XFILLER_0_13_125 VGND VGND VPWR VPWR sky130_fd_sc_hd__decap_3
XTAP_TAPCELL_ROW_2_51 VGND VPWR sky130_fd_sc_hd__tapvpwrvgnd_1
X_170_ _065_ _106_ VGND VGND VPWR VPWR _107_ sky130_fd_sc_hd__and2_1
XPHY_EDGE_ROW_21_Left_43 VGND VGND VPWR VPWR sky130_fd_sc_hd__decap_3
XFILLER_0_3_23 VPWR VGND VPWR VGND sky130_ef_sc_hd__decap_12
XTAP_TAPCELL_ROW_12_71 VGND VPWR sky130_fd_sc_hd__tapvpwrvgnd_1
X_222_ _043_ _044_ VGND VGND VPWR VPWR _045_ sky130_fd_sc_hd__nand2_1
X_153_ _090_ curr_state\[0\] VGND VGND VPWR VPWR _091_ sky130_fd_sc_hd__nand2_1
X_205_ _020_ VGND VGND VPWR VPWR _031_ sky130_fd_sc_hd__inv_2
X_136_ _075_ VGND VGND VPWR VPWR _076_ sky130_fd_sc_hd__inv_2
XFILLER_0_0_57 VPWR VGND VPWR VGND sky130_ef_sc_hd__decap_12
XFILLER_0_9_33 VGND VGND VPWR VPWR sky130_fd_sc_hd__decap_8
X_119_ _057_ _058_ VGND VGND VPWR VPWR _059_ sky130_fd_sc_hd__nand2_1
XFILLER_0_8_120 VGND VGND VPWR VPWR sky130_fd_sc_hd__decap_8
XFILLER_0_12_26 VGND VGND VPWR VPWR sky130_fd_sc_hd__fill_2
XFILLER_0_12_37 VPWR VGND VPWR VGND sky130_ef_sc_hd__decap_12
XFILLER_0_5_101 VGND VGND VPWR VPWR sky130_fd_sc_hd__decap_8
XFILLER_0_2_126 VGND VGND VPWR VPWR sky130_fd_sc_hd__fill_2
XFILLER_0_3_35 VPWR VGND VPWR VGND sky130_ef_sc_hd__decap_12
XFILLER_0_13_91 VPWR VGND VPWR VGND sky130_ef_sc_hd__decap_12
X_221_ _098_ _036_ VGND VGND VPWR VPWR _044_ sky130_fd_sc_hd__or2_1
XTAP_TAPCELL_ROW_8_62 VGND VPWR sky130_fd_sc_hd__tapvpwrvgnd_1
X_152_ _066_ _064_ VGND VGND VPWR VPWR _090_ sky130_fd_sc_hd__nor2_1
X_204_ _014_ curr_state\[2\] _021_ VGND VGND VPWR VPWR _030_ sky130_fd_sc_hd__nand3_1
XFILLER_0_0_69 VPWR VGND VPWR VGND sky130_ef_sc_hd__decap_12
XFILLER_0_9_45 VGND VGND VPWR VPWR sky130_fd_sc_hd__decap_4
X_135_ seq_timer\[2\] _072_ _074_ VGND VGND VPWR VPWR _075_ sky130_fd_sc_hd__or3_1
XTAP_TAPCELL_ROW_18_82 VGND VPWR sky130_fd_sc_hd__tapvpwrvgnd_1
X_118_ seq_timer\[1\] seq_timer\[0\] VGND VGND VPWR VPWR _058_ sky130_fd_sc_hd__nand2_1
XFILLER_0_15_7 VGND VGND VPWR VPWR sky130_fd_sc_hd__decap_8
XFILLER_0_12_49 VPWR VGND VPWR VGND sky130_ef_sc_hd__decap_12
XFILLER_0_5_113 VPWR VGND VPWR VGND sky130_ef_sc_hd__decap_12
XFILLER_0_3_69 VGND VGND VPWR VPWR sky130_fd_sc_hd__fill_2
XFILLER_0_3_47 VGND VGND VPWR VPWR sky130_fd_sc_hd__decap_4
XFILLER_0_18_59 VGND VGND VPWR VPWR sky130_fd_sc_hd__fill_1
XFILLER_0_18_15 VGND VGND VPWR VPWR sky130_fd_sc_hd__decap_4
X_220_ _040_ _073_ VGND VGND VPWR VPWR _043_ sky130_fd_sc_hd__nand2_1
X_151_ _087_ _088_ VGND VGND VPWR VPWR _089_ sky130_fd_sc_hd__nand2_1
XTAP_TAPCELL_ROW_8_63 VGND VPWR sky130_fd_sc_hd__tapvpwrvgnd_1
XFILLER_0_20_49 VGND VGND VPWR VPWR sky130_fd_sc_hd__decap_6
X_134_ _060_ _061_ _073_ VGND VGND VPWR VPWR _074_ sky130_fd_sc_hd__nand3_1
X_203_ _027_ _028_ VGND VGND VPWR VPWR _029_ sky130_fd_sc_hd__nand2_1
XTAP_TAPCELL_ROW_18_83 VGND VPWR sky130_fd_sc_hd__tapvpwrvgnd_1
XFILLER_0_9_57 VGND VGND VPWR VPWR sky130_fd_sc_hd__decap_3
XFILLER_0_9_79 VGND VGND VPWR VPWR sky130_fd_sc_hd__fill_2
X_117_ seq_timer\[3\] seq_timer\[2\] VGND VGND VPWR VPWR _057_ sky130_fd_sc_hd__nor2_1
XFILLER_0_5_125 VGND VGND VPWR VPWR sky130_fd_sc_hd__decap_3
XFILLER_0_2_106 VPWR VGND VPWR VGND sky130_ef_sc_hd__decap_12
X_150_ wake_up_sync VGND VGND VPWR VPWR _088_ sky130_fd_sc_hd__inv_2
XPHY_EDGE_ROW_16_Right_16 VGND VGND VPWR VPWR sky130_fd_sc_hd__decap_3
X_133_ seq_timer\[3\] VGND VGND VPWR VPWR _073_ sky130_fd_sc_hd__inv_2
X_202_ net20 seq_timer\[0\] VGND VGND VPWR VPWR _028_ sky130_fd_sc_hd__nand2_1
XFILLER_0_0_27 VGND VGND VPWR VPWR sky130_fd_sc_hd__fill_1
XPHY_EDGE_ROW_12_Left_34 VGND VGND VPWR VPWR sky130_fd_sc_hd__decap_3
XFILLER_0_21_82 VGND VGND VPWR VPWR sky130_fd_sc_hd__fill_2
XPHY_EDGE_ROW_2_Right_2 VGND VGND VPWR VPWR sky130_fd_sc_hd__decap_3
XFILLER_0_6_37 VPWR VGND VPWR VGND sky130_ef_sc_hd__decap_12
XFILLER_0_4_9 VPWR VGND VPWR VGND sky130_ef_sc_hd__decap_12
XFILLER_0_12_18 VGND VGND VPWR VPWR sky130_fd_sc_hd__decap_8
XFILLER_0_11_3 VGND VGND VPWR VPWR sky130_fd_sc_hd__decap_8
XFILLER_0_2_118 VGND VGND VPWR VPWR sky130_fd_sc_hd__decap_8
XFILLER_0_13_83 VGND VGND VPWR VPWR sky130_fd_sc_hd__decap_4
XPHY_EDGE_ROW_0_Left_22 VGND VGND VPWR VPWR sky130_fd_sc_hd__decap_3
XFILLER_0_0_3 VGND VGND VPWR VPWR sky130_fd_sc_hd__fill_1
X_201_ seq_timer\[0\] net20 VGND VGND VPWR VPWR _027_ sky130_fd_sc_hd__or2_1
X_132_ _070_ _071_ VGND VGND VPWR VPWR _072_ sky130_fd_sc_hd__nand2_1
XFILLER_0_19_113 VPWR VGND VPWR VGND sky130_ef_sc_hd__decap_12
XFILLER_0_15_18 VGND VGND VPWR VPWR sky130_fd_sc_hd__decap_3
XTAP_TAPCELL_ROW_20_86 VGND VPWR sky130_fd_sc_hd__tapvpwrvgnd_1
XFILLER_0_16_127 VGND VGND VPWR VPWR sky130_fd_sc_hd__fill_1
XFILLER_0_16_72 VPWR VGND VPWR VGND sky130_ef_sc_hd__decap_12
XFILLER_0_6_27 VGND VGND VPWR VPWR sky130_fd_sc_hd__fill_1
XFILLER_0_6_49 VGND VGND VPWR VPWR sky130_fd_sc_hd__decap_6
.ends
